* C:\Users\gakka\OneDrive - Cyprus University of Technology\Desktop\Everything\Panepistimiaka\Hlektronika Kiklomata\Lab Xarys Eystathiou\Practice for Final Test\Schematic1.sch

* Schematics Version 9.1 - Web Update 1
* Mon Nov 25 13:55:35 2024

** Analysis setup **
.OP

* From [PSPICE NETLIST] section of pspiceev.ini:
.lib "nom.lib"

.INC "Schematic1.net"
.INC "Schematic1.als"

.probe

.END
