* C:\Users\gakka\OneDrive - Cyprus University of Technology\Desktop\Everything\Studies\Hlektronika Kiklomata\Lab Xarys Eystathiou\Ergastirio 5 PsPice\erg5prdgm1.sch

* Schematics Version 9.1 - Web Update 1
* Sun Oct 20 23:25:13 2024

** Analysis setup **
.DC LIN PARAM R2 0.1 10 1
.OP

* From [PSPICE NETLIST] section of pspiceev.ini:
.lib "nom.lib"

.INC "erg5prdgm1.net"
.INC "erg5prdgm1.als"

.probe

.END
